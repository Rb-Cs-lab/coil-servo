# Ansys Electronics Desktop project, version 2025.2

design bench_ft (Circuit)
options: SParamCircuitDef IntegrationMethod=FFT
components:
  PSU = DC_SUPPLY(VSET=V_sup ILIM=I_lim COUT=C_sup RREG=R_reg)
  R_lead = RES_(R=R_lead)
  L_lead = IND_(L=L_lead)
  R_lead_ac = RES_(R=R_lead_ac)
  V_logic5 = V_DC(DC=5V)
  D_block = SCHOTTKY_DSS2X101(RLEAK=R_bleed)
  D_clamp = TVS_5KP30A(CJ=C_rail)
  Q1 = BRIDGE_SWITCH()
  Q2 = BRIDGE_SWITCH()
  Q3 = BRIDGE_SWITCH()
  Q4 = BRIDGE_SWITCH()
  R_damp1 = RES_(R=R_damp1)
  R_damp2 = RES_(R=R_damp2)
  C_damp = CAP_(C=C_damp)
  RV1 = VARISTOR_S20K20()
  LEM = LEM_LF310S()
  L_coil = IND_(L=L_coil)
  R_coil = RES_(R=R_coil)
  M1 = PASS_LEG(VT=vt_pass+(-0.0050) CGD=cgd_pass CGS=23e-9-cgd_pass K=k_pass)
  M2 = PASS_LEG(VT=vt_pass+(+0.0050) CGD=cgd_pass CGS=23e-9-cgd_pass K=k_pass)
  M3 = PASS_LEG(VT=vt_pass+(-0.0050) CGD=cgd_pass CGS=23e-9-cgd_pass K=k_pass)
  M4 = PASS_LEG(VT=vt_pass+(+0.0350) CGD=cgd_pass CGS=23e-9-cgd_pass K=k_pass)
  M5 = PASS_LEG(VT=vt_pass+(-0.0250) CGD=cgd_pass CGS=23e-9-cgd_pass K=k_pass)
  M6 = PASS_LEG(VT=vt_pass+(-0.0050) CGD=cgd_pass CGS=23e-9-cgd_pass K=k_pass)
  D_tvs = TVS_5KP12CA()
  R_term = RES_(R=R_term)
  U_opa = OPA994()
  R_f = RES_(R=6.98kOhm)
  R_g = RES_(R=1kOhm)
  V_opamp = V_DC(DC=V_opamp)
  R_burden = RES_(R=10ohm)
  U_ina = AD8421()
  R_ser = RES_(R=49.9ohm)
  X_in1 = TEST_LINK()
  C_cable = CAP_(C=150pF)
  U_rp = RP_SERVO(KP=kp KI=ki CLAMP=u_clamp FLOOR=u_floor TRIP=trip_amps SNAP=snap_amps)
  U_logic = LOGIC_BOARD()
  X_hb = TEST_LINK()
  V_setpoint = V_PULSE(V1=0 V2=sp_amps/200 TD=t_sp_on TR=sp_amps/slew_up*1s+10ns TF=sp_fall PW=t_sp_len PER=10s)
  V_setpoint2 = V_PULSE(V1=0 V2=sp2_amps/200 TD=t_sp2_on TR=abs(sp2_amps)/slew2*1s+10ns TF=1us PW=10s PER=20s)
  V_run = V_PULSE(V1=1 V2=0 TD=t_run_off TR=10ns TF=10ns PW=t_run_len PER=20s)
  V_openloop = V_PULSE(V1=ol_kcounts V2=ol_kcounts+ol_step TD=t_ol_step TR=t_ol_ramp TF=10ns PW=10s PER=20s)
  V_dio0_pol = V_PULSE(V1=3.3 V2=0 TD=t_pol TR=10ns TF=10ns PW=10s PER=20s)
  V_dio1_en = V_PULSE(V1=0 V2=3.3 TD=10us TR=10ns TF=10ns PW=t_en_off-10us PER=t_en_off-10us+en_gap)
  V_dio6_hb = V_PULSE(V1=0 V2=3.3 TD=1us TR=10ns TF=10ns PW=524us PER=1048us)
  V_reset = V_PULSE(V1=0 V2=3.3 TD=3us TR=10ns TF=10ns PW=4us PER=t_rst_per)
  V_hb_wire = V_PULSE(V1=1 V2=0 TD=t_hb_off TR=10ns TF=10ns PW=t_hb_len PER=20s)
  V_in1_cable = V_PULSE(V1=1 V2=0 TD=t_in1_off TR=10ns TF=10ns PW=10s PER=20s)
nets:
  0: PSU.1, V_logic5.1, M6.4, M3.4, U_opa.4, M2.4, D_tvs.1, M5.4, M1.4, U_ina.0, U_ina.2, V_opamp.1, R_g.0, M4.4, V_run.1, V_openloop.1, R_term.0, R_burden.0, C_cable.0, V_setpoint.1, V_dio0_pol.1, V_dio1_en.1, V_dio6_hb.1, V_reset.1, V_hb_wire.1, V_in1_cable.1
  A: Q3.d, RV1.0, LEM.1, R_damp1.0, Q1.s
  B: C_damp.1, Q2.s, RV1.1, Q4.d, R_coil.1
  coil_a: L_coil.0, LEM.0
  coil_m: L_coil.1, R_coil.0
  dio0: U_rp.3, U_logic.0, V_dio0_pol.0
  dio1: U_logic.1, V_dio1_en.0
  dio6: X_hb.1, U_logic.2
  dio6_rp: X_hb.0, V_dio6_hb.0
  dis: Q3.inn, Q2.inn, Q4.inn, U_logic.6, Q1.inn
  dmp1: R_damp2.0, R_damp1.1
  dmp2: C_damp.0, R_damp2.1
  fb: R_f.0, U_opa.1, R_g.1
  g1: Q1.g
  g2: Q2.g
  g3: Q3.g
  g4: Q4.g
  gate_bus: R_f.1, M6.1, M3.1, U_opa.2, M2.1, M5.1, M1.1, M4.1
  hb_ok: U_logic.7
  hb_wire: X_hb.2, V_hb_wire.0
  i_meas: U_rp.7
  in1: U_rp.0, X_in1.1, C_cable.1
  in1_ok: X_in1.2, V_in1_cable.0
  in1_src: R_ser.1, X_in1.0
  in2: U_rp.1, V_setpoint2.0
  ina_out: R_ser.0, U_ina.3
  latch_trip: U_logic.8
  lead_m: R_lead.1, L_lead.0, R_lead_ac.0
  lem_m: LEM.2, U_ina.1, R_burden.1
  npol: Q3.inp, Q2.inp, U_logic.5
  ol: U_rp.5, V_openloop.0
  out1: U_opa.0, U_rp.2, R_term.1
  pg1: M1.2
  pg2: M2.2
  pg3: M3.2
  pg4: M4.2
  pg5: M5.2
  pg6: M6.2
  pol: Q4.inp, U_logic.4, Q1.inp
  ps1: M1.3
  ps2: M2.3
  ps3: M3.3
  ps4: M4.3
  ps5: M5.3
  ps6: M6.3
  rail: D_block.1, D_clamp.0, Q2.d, Q1.d
  rail_in: L_lead.1, R_lead_ac.1, D_block.0
  ret: D_clamp.1, Q3.s, Q4.s, M6.0, M3.0, M2.0, D_tvs.0, M5.0, M1.0, M4.0
  rst: U_logic.3, V_reset.0
  run: U_rp.4, V_run.0
  sp_b: V_setpoint2.1, V_setpoint.0
  sup_p: PSU.0, R_lead.0
  u_kcounts: U_rp.6
  v5: V_logic5.0, Q3.v5, Q2.v5, Q4.v5, Q1.v5
  vop: U_opa.3, V_opamp.0
setups:
  Tran_600us: TransientData(50ns, 600us) TransientNoiseData(false, "", "", 0, 1, 0, false, 1) TransientOtherData(default, false, false)
  Tran_3ms: TransientData(200ns, 3ms) TransientNoiseData(false, "", "", 0, 1, 0, false, 1) TransientOtherData(default, false, false)
  Tran_12ms: TransientData(500ns, 12ms) TransientNoiseData(false, "", "", 0, 1, 0, false, 1) TransientOtherData(default, false, false)

design mot_ft (Circuit)
options: SParamCircuitDef IntegrationMethod=FFT
components:
  PSU = DC_SUPPLY(VSET=V_sup ILIM=I_lim COUT=C_sup RREG=R_reg)
  R_lead = RES_(R=R_lead)
  L_lead = IND_(L=L_lead)
  R_lead_ac = RES_(R=R_lead_ac)
  V_logic5 = V_DC(DC=5V)
  D_block = SCHOTTKY_DSS2X101(RLEAK=R_bleed)
  D_clamp = TVS_5KP30A(CJ=C_rail)
  Q1 = BRIDGE_SWITCH()
  Q2 = BRIDGE_SWITCH()
  Q3 = BRIDGE_SWITCH()
  Q4 = BRIDGE_SWITCH()
  R_damp1 = RES_(R=R_damp1)
  C_damp = CAP_(C=C_damp)
  RV1 = VARISTOR_S20K20()
  L_coil1 = IND_(L=L_coil)
  R_coil1 = RES_(R=R_coil)
  LEM = LEM_LF310S()
  L_coil = IND_(L=L_coil)
  R_coil = RES_(R=R_coil)
  RV2 = VARISTOR_S20K20()
  M1 = PASS_LEG(VT=vt_pass+(-0.0050) CGD=cgd_pass CGS=23e-9-cgd_pass K=k_pass)
  M2 = PASS_LEG(VT=vt_pass+(+0.0050) CGD=cgd_pass CGS=23e-9-cgd_pass K=k_pass)
  M3 = PASS_LEG(VT=vt_pass+(-0.0050) CGD=cgd_pass CGS=23e-9-cgd_pass K=k_pass)
  M4 = PASS_LEG(VT=vt_pass+(+0.0350) CGD=cgd_pass CGS=23e-9-cgd_pass K=k_pass)
  M5 = PASS_LEG(VT=vt_pass+(-0.0250) CGD=cgd_pass CGS=23e-9-cgd_pass K=k_pass)
  M6 = PASS_LEG(VT=vt_pass+(-0.0050) CGD=cgd_pass CGS=23e-9-cgd_pass K=k_pass)
  D_tvs = TVS_5KP12CA()
  R_term = RES_(R=R_term)
  U_opa = OPA994()
  R_f = RES_(R=6.98kOhm)
  R_g = RES_(R=1kOhm)
  V_opamp = V_DC(DC=V_opamp)
  R_burden = RES_(R=10ohm)
  U_ina = AD8421()
  R_ser = RES_(R=49.9ohm)
  X_in1 = TEST_LINK()
  C_cable = CAP_(C=150pF)
  U_rp = RP_SERVO(KP=kp KI=ki CLAMP=u_clamp FLOOR=u_floor TRIP=trip_amps SNAP=snap_amps)
  U_logic = LOGIC_BOARD()
  X_hb = TEST_LINK()
  V_setpoint = V_PULSE(V1=0 V2=sp_amps/200 TD=t_sp_on TR=sp_amps/slew_up*1s+10ns TF=sp_fall PW=t_sp_len PER=10s)
  V_setpoint2 = V_PULSE(V1=0 V2=sp2_amps/200 TD=t_sp2_on TR=abs(sp2_amps)/slew2*1s+10ns TF=1us PW=10s PER=20s)
  V_run = V_PULSE(V1=1 V2=0 TD=t_run_off TR=10ns TF=10ns PW=t_run_len PER=20s)
  V_openloop = V_PULSE(V1=ol_kcounts V2=ol_kcounts+ol_step TD=t_ol_step TR=t_ol_ramp TF=10ns PW=10s PER=20s)
  V_dio0_pol = V_PULSE(V1=3.3 V2=0 TD=t_pol TR=10ns TF=10ns PW=10s PER=20s)
  V_dio1_en = V_PULSE(V1=0 V2=3.3 TD=10us TR=10ns TF=10ns PW=t_en_off-10us PER=t_en_off-10us+en_gap)
  V_dio6_hb = V_PULSE(V1=0 V2=3.3 TD=1us TR=10ns TF=10ns PW=524us PER=1048us)
  V_reset = V_PULSE(V1=0 V2=3.3 TD=3us TR=10ns TF=10ns PW=4us PER=t_rst_per)
  V_hb_wire = V_PULSE(V1=1 V2=0 TD=t_hb_off TR=10ns TF=10ns PW=t_hb_len PER=20s)
  V_in1_cable = V_PULSE(V1=1 V2=0 TD=t_in1_off TR=10ns TF=10ns PW=10s PER=20s)
nets:
  0: PSU.1, V_logic5.1, M1.4, M2.4, M3.4, M4.4, M6.4, M5.4, V_opamp.1, U_ina.0, U_ina.2, V_dio1_en.1, D_tvs.1, U_opa.4, V_openloop.1, V_setpoint.1, V_hb_wire.1, R_term.0, V_dio0_pol.1, R_g.0, C_cable.0, R_burden.0, V_run.1, V_dio6_hb.1, V_reset.1, V_in1_cable.1
  A: Q1.s, R_damp1.0, RV1.0, Q3.d, L_coil1.0
  B: Q4.d, Q2.s, R_coil.1, RV2.1, C_damp.1
  c1: R_coil1.0, L_coil1.1
  coil_a: LEM.0, L_coil.0, RV2.0
  coil_m: L_coil.1, R_coil.0
  dio0: U_rp.3, V_dio0_pol.0, U_logic.0
  dio1: V_dio1_en.0, U_logic.1
  dio6: U_logic.2, X_hb.1
  dio6_rp: X_hb.0, V_dio6_hb.0
  dis: Q1.inn, Q4.inn, Q2.inn, Q3.inn, U_logic.6
  dmp2: R_damp1.1, C_damp.0
  fb: U_opa.1, R_f.0, R_g.1
  g1: Q1.g
  g2: Q2.g
  g3: Q3.g
  g4: Q4.g
  gate_bus: M1.1, M2.1, M3.1, M4.1, M6.1, M5.1, U_opa.2, R_f.1
  hb_ok: U_logic.7
  hb_wire: V_hb_wire.0, X_hb.2
  i_meas: U_rp.7
  in1: U_rp.0, X_in1.1, C_cable.1
  in1_ok: X_in1.2, V_in1_cable.0
  in1_src: X_in1.0, R_ser.1
  in2: U_rp.1, V_setpoint2.0
  ina_out: U_ina.3, R_ser.0
  latch_trip: U_logic.8
  lead_m: R_lead.1, R_lead_ac.0, L_lead.0
  lem_m: LEM.2, U_ina.1, R_burden.1
  mid_a: RV1.1, R_coil1.1, LEM.1
  npol: Q2.inp, Q3.inp, U_logic.5
  ol: U_rp.5, V_openloop.0
  out1: U_rp.2, U_opa.0, R_term.1
  pg1: M1.2
  pg2: M2.2
  pg3: M3.2
  pg4: M4.2
  pg5: M5.2
  pg6: M6.2
  pol: Q1.inp, Q4.inp, U_logic.4
  ps1: M1.3
  ps2: M2.3
  ps3: M3.3
  ps4: M4.3
  ps5: M5.3
  ps6: M6.3
  rail: D_clamp.0, Q1.d, Q2.d, D_block.1
  rail_in: R_lead_ac.1, L_lead.1, D_block.0
  ret: D_clamp.1, Q4.s, Q3.s, M1.0, M2.0, M3.0, M4.0, M6.0, M5.0, D_tvs.0
  rst: U_logic.3, V_reset.0
  run: U_rp.4, V_run.0
  sp_b: V_setpoint.0, V_setpoint2.1
  sup_p: R_lead.0, PSU.0
  u_kcounts: U_rp.6
  v5: Q1.v5, Q4.v5, Q2.v5, Q3.v5, V_logic5.0
  vop: V_opamp.0, U_opa.3
setups:
  Tran_600us: TransientData(50ns, 600us) TransientNoiseData(false, "", "", 0, 1, 0, false, 1) TransientOtherData(default, false, false)
  Tran_3ms: TransientData(200ns, 3ms) TransientNoiseData(false, "", "", 0, 1, 0, false, 1) TransientOtherData(default, false, false)
  Tran_12ms: TransientData(500ns, 12ms) TransientNoiseData(false, "", "", 0, 1, 0, false, 1) TransientOtherData(default, false, false)
